** Profile: "SCHEMATIC1-AC"  [ c:\users\a0227588\documents\spice models\xtr200\xtr200-PSpiceFiles\SCHEMATIC1\AC.sim ]

** Creating circuit file "AC.cir"
** WARNING: THIS AUTOMATICALLY GENERATED FILE MAY BE OVERWRITTEN BY SUBSEQUENT SIMULATIONS

*Libraries:
* Profile Libraries :
* Local Libraries :
.LIB "c:/users/a0227588/documents/spice models/xtr200_current/xtr200 library/xtr200.lib"
* From [PSPICE NETLIST] section of C:\SPB_Data-Silent\cdssetup\OrCAD_PSpice\23.1.0\PSpice.ini file:
.lib "C:\Users\a0227588\Downloads\OPA348_PSpice\opa348.lib"
.lib "C:\Users\a0227588\Documents\Spice Models\Autospice Test Models\Other\Autospice_Library.lib"
.lib "nom.lib"

*Analysis directives:
.AC DEC 100 1 10MEG
.OPTIONS ADVCONV
.PROBE64 V(alias(*)) I(alias(*)) W(alias(*)) D(alias(*)) NOISE(alias(*))
.INC "..\SCHEMATIC1.net"

.END

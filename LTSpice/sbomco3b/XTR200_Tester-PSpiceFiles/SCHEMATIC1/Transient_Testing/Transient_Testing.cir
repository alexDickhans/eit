** Profile: "SCHEMATIC1-Transient_Testing"  [ c:\users\a0227588\documents\spice models\xtr200\xtr200_tester-pspicefiles\schematic1\transient_testing.sim ]

** Creating circuit file "Transient_Testing.cir"
** WARNING: THIS AUTOMATICALLY GENERATED FILE MAY BE OVERWRITTEN BY SUBSEQUENT SIMULATIONS

*Libraries:
* Profile Libraries :
* Local Libraries :
.LIB "c:/users/a0227588/documents/spice models/xtr200_current/xtr200 library/xtr200.lib"
* From [PSPICE NETLIST] section of C:\SPB_Data-Silent\cdssetup\OrCAD_PSpice\23.1.0\PSpice.ini file:
.lib "C:\Users\a0227588\Downloads\OPA348_PSpice\opa348.lib"
.lib "C:\Users\a0227588\Documents\Spice Models\Autospice Test Models\Other\Autospice_Library.lib"
.lib "nom.lib"

*Analysis directives:
.TRAN  0 2m 0
.OPTIONS ADVCONV
.PROBE64 V(alias(*)) I(alias(*)) W(alias(*)) D(alias(*)) NOISE(alias(*))
.INC "..\SCHEMATIC1.net"

.END
